* NAND gate using the ngspice XSPICE digital primitive (event-driven, reliable).
* ADC/DAC bridges provide analog inputs and a 0/3.3 V output. Truth table: 11->0.
* Different pulse periods exercise all four input combinations.
vdummy dummy 0 DC=0
VA a 0 PULSE(0 3.3 0 0 1n 1u 2u)
VB b 0 PULSE(0 3.3 0 0 1n 0.5u 1u)
a_input [a b] [da db] adc1
a_x [da db] dout nand1
a_output [dout] [out] dac1

.model adc1 adc_bridge (in_low=0.7 in_high=1.6)
.model nand1 d_nand (rise_delay=1n fall_delay=1n)
.model dac1 dac_bridge (out_low=0 out_high=3.3)

.control
set noaskquit
tran 0.01u 2u
wrdata v_out.csv v(out)
wrdata v_a.csv v(a)
wrdata v_b.csv v(b)
.endc
.end
