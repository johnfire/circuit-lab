* NAND gate using the ngspice XSPICE digital primitive (event-driven, reliable).
* Output reads as logic level 0/1 (NOT the rail voltage). Truth table: 11->0.
* Drive both inputs anyway; the result verifies the gate logic.
vdummy dummy 0 DC=0
VA a 0 PULSE(0 3.3 0 0 1n 1u 2u)
VB b 0 PULSE(0 3.3 0 0 1n 0.5u 2u)
a_x [a b] out nand1

.model nand1 d_nand (rise_delay=1n fall_delay=1n in_low=0.7 in_high=1.6 out_low=0 out_high=3.3)

.control
set noaskquit
tran 0.01u 2u
wrdata v_out.csv v(out)
.endc
.end
