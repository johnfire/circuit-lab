* Behavioral NAND gate (3.3V logic) — out HIGH unless both inputs HIGH
VA in1 0 PULSE(0 3.3 0 1n 1n 0.5u 1u)
VB in2 0 PULSE(0 3.3 0 1n 1n 1u 2u)
B1 out 0 V = 3.3 * ((V(in1) < 1.65) | (V(in2) < 1.65))

.control
tran 10n 4u
wrdata v_in1.csv V(in1)
wrdata v_in2.csv V(in2)
wrdata v_out.csv V(out)
.endc
.end
